// The fast-math benchmark's boundary model (`zig build bench-fast`): the
// square-law MOSFET of mosfet.va plus one §4.3 exp, a subthreshold leakage
// term. The least transcendental work that still makes codegen version the
// body (DeclGen's `transcendental`), so it probes the rule's edge.
`include "disciplines.vams"
module bench_mos_exp(d, g, s, b);
  inout d, g, s, b;
  electrical d, g, s, b;
  parameter real vto = 0.7 from [-5:5];
  parameter real kp = 2e-5 from (0:1e-2];
  parameter real w = 10e-6 from [1e-8:1e-2];
  parameter real l = 1e-6 from [1e-8:1e-2];
  parameter real lambda = 0.02 from [0:1];
  parameter real gamma = 0.4 from [0:3];
  parameter real phi = 0.65 from [0.1:2];
  parameter real i0 = 1e-15 from [0:1e-9];
  parameter real ns = 1.5 from [1.5:3];
  real vgs, vds, vbs, vth, vov, beta, ids, sq;
  analog begin
    vgs = V(g, s);
    vds = V(d, s);
    vbs = V(b, s);
    beta = kp * w / l;
    sq = sqrt(phi - (vbs < 0 ? vbs : 0) + 1e-3);
    vth = vto + gamma * (sq - sqrt(phi));
    vov = vgs - vth;
    if (vov <= 0)
      ids = 0;
    else if (vds < vov)
      ids = beta * (vov - 0.5 * vds) * vds * (1 + lambda * vds);
    else
      ids = 0.5 * beta * vov * vov * (1 + lambda * vds);
    I(d, s) <+ ids + i0 * exp(vgs / (ns * 0.025852)) * vds + 1e-12 * vds;
  end
endmodule
